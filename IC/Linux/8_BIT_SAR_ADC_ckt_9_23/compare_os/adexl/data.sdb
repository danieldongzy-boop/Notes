ADE simulation setup
Run mode: Monte Carlo Sampling
Tests:
  8-BIT-SAR-ADC-ckt:compare-os:1: 8-BIT-SAR-ADC-ckt/compare-os/schematic, simulator spectre
Global variables:
  CL = 100f
  fcom = 580M
Monte Carlo Sampling options: mcmethod=all, mcnumpoints=200
