ADE simulation setup
Run mode: Monte Carlo Sampling
Tests:
  8-BIT-SAR-ADC-ckt:cap_mc:1: 8-BIT-SAR-ADC-ckt/cap_mc/schematic, simulator spectre
Monte Carlo Sampling options: mcmethod=all, mcnumpoints=1000
