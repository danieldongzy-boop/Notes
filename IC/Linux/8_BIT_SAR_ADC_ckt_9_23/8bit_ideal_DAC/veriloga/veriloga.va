// VerilogA for 8-BIT-SAR-ADC, 8-bit-ideal-DAC, veriloga

`include "constants.vams"
`include "disciplines.vams"

module DAC_12bit (vd7, vd6, vd5, vd4, vd3, vd2, vd1, vd0, vout);
electrical  vd7, vd6, vd5, vd4, vd3, vd2, vd1, vd0, vout;
parameter real vref  = 1.8 from [0:inf);
parameter real trise = 1e-10 from [0:inf);
parameter real tfall = 1e-10 from [0:inf);
parameter real tdel  = 0    from [0:inf);
parameter real vtrans = 0.9;

	real out_scaled;

	analog begin
		out_scaled = 0.0;
		out_scaled = out_scaled + ((V(vd7) > vtrans) ? 128 : 0 );
		out_scaled = out_scaled + ((V(vd6) > vtrans) ? 64 : 0 );
		out_scaled = out_scaled + ((V(vd5) > vtrans) ? 32 : 0 );
		out_scaled = out_scaled + ((V(vd4) > vtrans) ? 16 : 0 );
		out_scaled = out_scaled + ((V(vd3) > vtrans) ? 8 : 0 );
		out_scaled = out_scaled + ((V(vd2) > vtrans) ? 4 : 0 );
		out_scaled = out_scaled + ((V(vd1) > vtrans) ? 2 : 0 );
		out_scaled = out_scaled + ((V(vd0) > vtrans) ? 1 : 0 );
		V(vout) <+ transition( vref*out_scaled/256, tdel, trise, tfall );
	end
endmodule
